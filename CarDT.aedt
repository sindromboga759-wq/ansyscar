# Ansys Electronics Desktop project, version 2024.2
materials:
  vacuum: permittivity=1

design HFSSDesign1 (HFSS, HFSS Modal Network, model units mm)
options: Save_Adaptive_support_files
geometry:
  wheels, wheels_1, wheels_2, wheels_3 [non-model] = imported_body(C:\Users\Ğ¡Ñ‚ĞµĞ¿Ğ°Ğ½\Downloads\car_model.step)
  body = imported_body(C:\Users\Ğ¡Ñ‚ĞµĞ¿Ğ°Ğ½\Downloads\car_model.step)
  RadiatingSurface [vacuum] = region(absolute_offset=89.445438mm on all sides)
  group car_model = wheels, wheels_1, wheels_2, wheels_3, body
boundaries and excitations:
  PerfE1: Perfect E Objects=body
  Open1: Radiation Objects=RadiatingSurface
  IncPWave1: Plane Incident Wave PhiStart=180deg PhiStop=180deg PhiPoints=1 ThetaStart=-90deg ThetaStop=90deg ThetaPoints=91 EoPhi=1 EoTheta=0 OriginX=0mm OriginY=0mm OriginZ=0mm IsPropagating
setups:
  Setup1: HfssDriven Frequency=1.118GHz MaxDeltaE=0.1 MaximumPasses=6 MinimumPasses=1 MinimumConvergedPasses=1 PercentRefinement=30 BasisOrder=1 DrivenSolverType="Direct Solver"
source amplitudes:
  IncPWave1:1: 1 0deg
radiation setups:
  3D: Infinite Sphere Theta=0deg..180deg step 2deg Phi=-180deg..180deg step 2deg
  Elevation: Infinite Sphere Theta=-180deg..180deg step 1deg Phi=0deg..90deg step 90deg
  Azimuth: Infinite Sphere Theta=90deg..90deg step 0deg Phi=-180deg..180deg step 1deg
reports:
  Monostatic RCS Plot 1: dBc(MonostaticRCSTotal) vs IWavePhi, IWaveTheta on Setup1 : LastAdaptive, 3D [Freq=1.118GHz Phi=-180deg Theta=0deg]
